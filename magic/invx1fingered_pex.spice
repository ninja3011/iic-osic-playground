* NGSPICE file created from invx1fingered.ext - technology: sky130A

X0 out in vss vss sky130_fd_pr__nfet_01v8 ad=0.189 pd=1.74 as=0.189 ps=1.74 w=0.42 l=0.15
X1 out in vdd vdd sky130_fd_pr__pfet_01v8 ad=0.2805 pd=1.51 as=0.33 ps=2.32 w=0.66 l=0.15 M=2
C0 vdd out 0.19448f
C1 vdd in 0.13534f
C2 in out 0.07329f
C3 out vss 0.32223f
C4 in vss 0.47335f
C5 vdd vss 0.8476f
